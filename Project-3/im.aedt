# Ansys Electronics Desktop project, version 2017.0
materials:
  steel_1010: permittivity=1 permeability{BType=normal HUnit=A_per_meter BUnit=tesla curve (0, 0) (238.7, 0.2003) (318.3, 0.3204) (358.1, 0.40045) (437.7, 0.50055) (477.5, 0.5606) (636.6, 0.7908) (795.8, 0.931) (1114.1, 1.1014) (1273.2, 1.2016) (1591.5, 1.302) (2228.2, 1.4028) (3183.1, 1.524) (4774.6, 1.626) (6366.2, 1.698) (7957.7, 1.73) (15915.5, 1.87) (31831, 1.99) (47746.5, 2.04) (63662, 2.07) (79577.5, 2.095) (159155, 2.2) (318310, 2.4)} conductivity=2000000 lande_g_factor=2 mass_density=7872
  copper: permeability=0.999991 conductivity=58000000 mass_density=8933

design RMxprtDesign1 (RMxprt, Three Phase Induction Motor, model units mm)
machine:
  Machine: FrictionLoss=50W WindLoss=0W ReferenceSpeed=1560rpm NumberOfPoles=6 StrayLossFactor=0.01
  Stator: SkewWidth=0 NumberOfSlots=72 LaminationSectors=0 PressBoardThickness=0mm OuterDiameter=890mm InnerDiameter=500mm Length=750mm StackingFactor=0.95 SteelType=steel_1010 SlotType=4
  Rotor: OuterDiameter=496.3mm InnerDiameter=280mm Length=750mm SteelType=steel_1010 NumberOfSlots=84 SlotType=2 SkewWidth=2 CastRotor BottomSlotType=UserDefinedSlot StackingFactor=0.95
  Shaft:
  Stator Slot: Hs0=1mm Hs1=1mm Hs2=120mm Bs0=2mm Bs1=10mm Bs2=16mm Rs=1mm ToothWidth=0mm
  Stator Winding: WindingType=Whole-Coiled WindingLayers=1 ParallelBranches=1 ConductorsPerSlot=2 CoilPitch=1 EndAdjustment=0mm BaseInnerRadius=0mm TipInnerDiameter=0mm EndClearance=0mm CoilWrap=0mm SlotLiner=0mm WedgeThickness=0mm LayerInsulation=0mm BottomInsulation=0mm LimitedFillFactor=0.5 WdgNumberofPriodicMultipler=1 NumberOfStrands=1 WireWrap=0mm InterturnInsulation=0mm WireDiameter=0.724mm WireWidth=0mm WireThickness=0mm Gauge=21
  Rotor Slot: Hs0=2mm Hs1=2.5mm Hs2=30mm Bs0=2mm Bs1=10mm Bs2=8mm Rs=0mm Hs01=0mm
  Rotor Winding: BarConductorType=copper EndLength=0mm EndRingWidth=12mm EndRingHeight=20mm EndRingConductorType=copper
setups:
  Setup1: TPIM Motor RatedOutputPower=1280kW RatedVoltage=1350V RatedSpeed=1520rpm OperatingTemperature=75cel LoadType=ConstSpeed Frequency=78Hz WindingConnection=0
