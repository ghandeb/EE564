# Ansys Electronics Desktop project, version 2017.0
materials:
  steel_1010: permittivity=1 permeability{BType=normal HUnit=A_per_meter BUnit=tesla curve (0, 0) (238.7, 0.2003) (318.3, 0.3204) (358.1, 0.40045) (437.7, 0.50055) (477.5, 0.5606) (636.6, 0.7908) (795.8, 0.931) (1114.1, 1.1014) (1273.2, 1.2016) (1591.5, 1.302) (2228.2, 1.4028) (3183.1, 1.524) (4774.6, 1.626) (6366.2, 1.698) (7957.7, 1.73) (15915.5, 1.87) (31831, 1.99) (47746.5, 2.04) (63662, 2.07) (79577.5, 2.095) (159155, 2.2) (318310, 2.4)} conductivity=2000000 lande_g_factor=2 mass_density=7872
  copper: permeability=0.999991 conductivity=58000000 mass_density=8933
  JFE_Steel_50JN600: core_loss_curve{50Hz (0, 0) (0.5, 0.73) (0.55, 0.811) (0.6, 0.916) (0.65, 1.026) (0.7, 1.145) (0.75, 1.271) (0.8, 1.416) (0.85, 1.556) (0.9, 1.717) (0.95, 1.877) (1, 2.046) (1.05, 2.231) (1.1, 2.416) (1.15, 2.637) (1.2, 2.857) (1.25, 3.09) (1.3, 3.346) (1.35, 3.61) (1.4, 3.9) (1.45, 4.24) (1.5, 4.59) (1.55, 4.94) (1.6, 5.3) (1.65, 5.7) (1.7, 6.15)} core_loss_curve{60Hz (0, 0) (0.5, 0.928) (0.55, 1.033) (0.6, 1.165) (0.65, 1.311) (0.7, 1.468) (0.75, 1.632) (0.8, 1.807) (0.85, 1.98) (0.9, 2.181) (0.95, 2.382) (1, 2.602) (1.05, 2.822) (1.1, 3.064) (1.15, 3.309) (1.2, 3.585) (1.25, 3.88) (1.3, 4.209) (1.35, 4.557) (1.4, 4.941) (1.45, 5.324) (1.5, 5.744) (1.55, 6.157) (1.6, 6.6) (1.65, 7.084) (1.7, 7.562)} core_loss_curve{100Hz (0, 0) (0.04, 0.01) (0.05, 0.0164) (0.06, 0.024) (0.07, 0.034) (0.08, 0.044) (0.09, 0.0563) (0.1, 0.0705) (0.15, 0.161) (0.2, 0.28) (0.25, 0.422) (0.3, 0.601) (0.35, 0.78) (0.4, 0.99) (0.45, 1.235) (0.5, 1.485) (0.55, 1.76) (0.6, 2.035) (0.65, 2.36) (0.7, 2.67) (0.75, 3) (0.8, 3.35) (0.85, 3.73) (0.9, 4.13) (0.95, 4.56) (1, 5) (1.1, 6) (1.2, 7.21) (1.3, 8.4) (1.4, 9.84) (1.5, 11.6)} core_loss_curve{200Hz (0, 0) (0.03, 0.014) (0.04, 0.026) (0.05, 0.0415) (0.06, 0.061) (0.07, 0.0845) (0.08, 0.112) (0.09, 0.143) (0.1, 0.178) (0.15, 0.398) (0.2, 0.683) (0.25, 1.032) (0.3, 1.471) (0.35, 1.945) (0.4, 2.475) (0.45, 3.061) (0.5, 3.699) (0.55, 4.389) (0.6, 5.131) (0.65, 6.032) (0.7, 6.901) (0.75, 7.809) (0.8, 8.762) (0.85, 9.969) (0.9, 11.04) (0.95, 12.411) (1, 13.6) (1.1, 16.75) (1.2, 20.25) (1.3, 24) (1.4, 28.6) (1.5, 34)} core_loss_curve{400Hz (0, 0) (0.02, 0.0164) (0.03, 0.039) (0.04, 0.071) (0.05, 0.113) (0.06, 0.166) (0.07, 0.228) (0.08, 0.3) (0.09, 0.38) (0.1, 0.473) (0.15, 1.05) (0.2, 1.8) (0.25, 2.753) (0.3, 3.825) (0.35, 5.15) (0.4, 6.541) (0.45, 8.078) (0.5, 9.753) (0.55, 11.803) (0.6, 14.075) (0.65, 15.909) (0.7, 18.532) (0.75, 20.962) (0.8, 24.004) (0.85, 27.301) (0.9, 30.857) (0.95, 34.681) (1, 38) (1.1, 47.9) (1.2, 59) (1.3, 71.9) (1.4, 87)} core_loss_curve{1kHz (0, 0) (0.01, 0.0201) (0.02, 0.083) (0.03, 0.189) (0.04, 0.333) (0.05, 0.515) (0.06, 0.74) (0.07, 1) (0.08, 1.2837) (0.09, 1.622) (0.1, 1.9612) (0.15, 4.3256) (0.2, 7.233) (0.25, 10.997) (0.3, 15.392) (0.35, 20.46) (0.4, 25.963) (0.45, 32.682) (0.5, 39.433) (0.55, 48.681) (0.6, 58.03) (0.65, 68.312) (0.7, 81.2) (0.75, 96)} core_loss_curve{2kHz (0, 0) (0.01, 0.069) (0.02, 0.286) (0.03, 0.635) (0.04, 1.0988) (0.05, 1.6757) (0.06, 2.33) (0.07, 3.1249) (0.08, 3.9701) (0.09, 4.9035) (0.1, 5.9556) (0.15, 12.4576) (0.2, 21.223) (0.25, 31.8) (0.3, 44.618) (0.35, 59.5) (0.4, 77) (0.45, 97.674)} core_loss_curve{5kHz (0, 0) (0.01, 0.348) (0.02, 1.3) (0.03, 2.76) (0.04, 4.7447) (0.05, 7.09) (0.06, 9.85) (0.07, 13.1728) (0.08, 16.6) (0.09, 20.4) (0.1, 24.7) (0.15, 50.5) (0.2, 84)} core_loss_curve{10kHz (0, 0) (0.01, 0.98) (0.02, 3.8) (0.03, 8.28) (0.04, 14.2) (0.05, 21.3) (0.06, 29.7) (0.07, 39.4) (0.08, 49.8) (0.09, 61.3) (0.1, 71.8)} permeability{BType=normal HUnit=A_per_meter BUnit=tesla curve (0, 0) (10, 0.015) (20, 0.019) (30, 0.04) (40, 0.068) (50, 0.103) (60, 0.182) (70, 0.32) (80, 0.463) (100, 0.747) (125, 1.01) (150, 1.128) (175, 1.203) (200, 1.259) (250, 1.326) (300, 1.367) (400, 1.416) (500, 1.444) (800, 1.499) (1000, 1.521) (1500, 1.562) (2000, 1.594) (2500, 1.618) (3000, 1.641) (4000, 1.679) (5000, 1.71) (8000, 1.785) (10000, 1.825) (15000, 1.899) (20000, 1.953) (30000, 2.022) (50000, 2.104) (80000, 2.153)} conductivity=3125000 core_loss_type="Electrical Steel" core_loss_kh=513.80714 core_loss_kc=0.46753057 core_loss_ke=4.1385302 mass_density=7750 stacking_type=Solid

design RMxprtDesign1 (RMxprt, Three Phase Induction Motor, model units mm)
machine:
  Machine: FrictionLoss=50W WindLoss=0W ReferenceSpeed=1560rpm NumberOfPoles=6 StrayLossFactor=0.01
  Stator: SkewWidth=0 NumberOfSlots=72 LaminationSectors=0 PressBoardThickness=0mm OuterDiameter=890mm InnerDiameter=500mm Length=750mm StackingFactor=0.95 SteelType=JFE_Steel_50JN600 SlotType=4
  Rotor: OuterDiameter=496.3mm InnerDiameter=280mm Length=750mm SteelType=steel_1010 NumberOfSlots=84 SlotType=2 SkewWidth=2 CastRotor BottomSlotType=UserDefinedSlot StackingFactor=0.95
  Shaft:
  Stator Slot: Hs0=1mm Hs1=1mm Hs2=120mm Bs0=2mm Bs1=10mm Bs2=16mm Rs=1mm ToothWidth=0mm
  Stator Winding: WindingType=Whole-Coiled WindingLayers=1 ParallelBranches=2 ConductorsPerSlot=4 CoilPitch=1 EndAdjustment=0mm BaseInnerRadius=0mm TipInnerDiameter=0mm EndClearance=0mm CoilWrap=0mm SlotLiner=0mm WedgeThickness=0mm LayerInsulation=0mm BottomInsulation=0mm LimitedFillFactor=0.5 WdgNumberofPriodicMultipler=1 NumberOfStrands=1 WireWrap=0mm InterturnInsulation=0mm WireDiameter=7.348mm WireWidth=0mm WireThickness=0mm Gauge=1
  Rotor Slot: Hs0=2mm Hs1=2.5mm Hs2=30mm Bs0=2mm Bs1=10mm Bs2=8mm Rs=0mm Hs01=0mm
  Rotor Winding: BarConductorType=copper EndLength=0mm EndRingWidth=12mm EndRingHeight=20mm EndRingConductorType=copper
setups:
  Setup1: TPIM Motor RatedOutputPower=1280kW RatedVoltage=1350V RatedSpeed=1520rpm OperatingTemperature=75cel LoadType=ConstPower Frequency=78Hz WindingConnection=0
